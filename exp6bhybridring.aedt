# Ansys Electronics Desktop project, version 2021.1
materials:
  vacuum: permittivity=1
  FR4_epoxy: permittivity=4.4 dielectric_loss_tangent=0.02
  air: permittivity=1.0006 permeability=1.0000004

design HFSSDesign1 (HFSS, DrivenModal, model units mm)
geometry:
  ground = regular_polygon(axis=Z, centre=(0mm, 0mm, 0mm), first_corner=(30/cos(30*pi/180) mm, 0mm, 0mm), sides=6)
  substrate [FR4_epoxy] = polyhedron(axis=Z, centre=(0mm, 0mm, 0mm), first_corner=(30/cos(30*pi/180) mm, 0mm, 0mm), sides=6, height=1.6mm)
  Circle1 = circle(normal=Z, centre=(0mm, 0mm, 1.6mm), radius=17.52mm)
  Circle2 = circle(normal=Z, centre=(0mm, 0mm, 1.6mm), radius=15.9mm)
  Circle1.subtract(Circle2)
  port1 = rectangle(corner=(-1.5mm, -30mm, 1.6mm), x_size=3mm, y_size=14mm)
  port2 = rectangle(corner=(-1.5mm, -30mm, 1.6mm), x_size=3mm, y_size=14mm)
  port3 = rectangle(corner=(-1.5mm, -30mm, 1.6mm), x_size=3mm, y_size=14mm)
  port4 = rectangle(corner=(-1.5mm, -30mm, 1.6mm), x_size=3mm, y_size=14mm)
  port2.rotate(axis=Z, angle=60deg)
  port3.rotate(axis=Z, angle=120deg)
  port4.rotate(axis=Z, angle=180deg)
  Circle1.unite(port1..port4)
  ground.rotate(axis=Z, angle=30deg)
  substrate.rotate(axis=Z, angle=30deg)
  Circle1.rotate(axis=Z, angle=30deg)
  [ground, substrate, Circle1].rotate(axis=Z, angle=30deg)
  port1_1 = rectangle(corner=(-1.5mm, 30mm, 1.6mm), z_size=-1.6mm, x_size=3mm)
  ground.rotate(axis=Z, angle=30deg)
  substrate.rotate(axis=Z, angle=30deg)
  Circle1.rotate(axis=Z, angle=30deg)
  port1_1.rotate(axis=Z, angle=30deg)
  [ground, substrate, Circle1, port1_1].rotate(axis=Z, angle=30deg)
  port2_1 = rectangle(corner=(1.5mm, 30mm, 1.6mm), z_size=-1.6mm, x_size=-3mm)
  ground.rotate(axis=Z, angle=30deg)
  substrate.rotate(axis=Z, angle=30deg)
  Circle1.rotate(axis=Z, angle=30deg)
  port1_1.rotate(axis=Z, angle=30deg)
  port2_1.rotate(axis=Z, angle=30deg)
  [ground, substrate, Circle1, port1_1, port2_1].rotate(axis=Z, angle=30deg)
  port3_1 = rectangle(corner=(1.5mm, 30mm, 1.6mm), z_size=-1.6mm, x_size=-3mm)
  port4_1 = rectangle(corner=(-1.5mm, -30mm, 1.6mm), z_size=-1.6mm, x_size=3mm)
  radiation [air] = box(corner=(-50mm, -50mm, -50mm), size=(100mm, 100mm, 100mm))
boundaries and excitations:
  PerfE1: Perfect E Objects=ground
  PerfE2: Perfect E Objects=Circle1
  1: Lumped Port Objects=port1_1 Modes{Mode1{IntLine{middle of port1_1.edge(2 of 4) -> middle of port1_1.edge(4 of 4)} CharImp=Zpi RenormImp=50ohm}} Impedance=50ohm
  2: Lumped Port Objects=port2_1 Modes{Mode1{IntLine{middle of port2_1.edge(2 of 4) -> middle of port2_1.edge(4 of 4)} CharImp=Zpi RenormImp=50ohm}} Impedance=50ohm
  3: Lumped Port Objects=port3_1 Modes{Mode1{IntLine{middle of port3_1.edge(z opposite corner) -> middle of port3_1.edge(z at corner)} CharImp=Zpi RenormImp=50ohm}} Impedance=50ohm
  4: Lumped Port Objects=port4_1 Modes{Mode1{IntLine{middle of port4_1.edge(z opposite corner) -> middle of port4_1.edge(z at corner)} CharImp=Zpi RenormImp=50ohm}} Impedance=50ohm
setups:
  Setup1: HfssDriven Frequency=2.4GHz MaxDeltaS=0.02 MaximumPasses=6 MinimumPasses=1 MinimumConvergedPasses=1 PercentRefinement=30 BasisOrder=1 PortAccuracy=2
    sweep Sweep: 1GHz to 5GHz, 100 points; Type=Interpolating InterpTolerance=0.5 InterpMaxSolns=250 InterpUsePortImped=false PassivityErrorTolerance=0.0001
source amplitudes:
  1:1: 1W 0deg
  2:1, 3:1, 4:1: 0W 0deg
reports:
  S Parameter Plot 1: dB(S(1,1)), dB(S(2,1)), dB(S(1,2)), dB(S(2,2)) vs Freq on Setup1 : Sweep; markers s11 at 2.5353535GHz, s22 at 2.5353535GHz, s21 at 2.3333333GHz, s12 at 2.3737374GHz
