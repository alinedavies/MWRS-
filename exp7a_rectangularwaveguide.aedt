# Ansys Electronics Desktop project, version 2021.1
materials:
  vacuum: permittivity=1

design HFSSDesign1 (HFSS, DrivenModal, model units mm)
variables:
  a = 22.86mm
  b = 10.16mm
  l = 60mm
geometry:
  waveguide [vacuum] = box(corner=(-a/2, -b/2, 0mm), size=(a, b, l))
boundaries and excitations:
  PerfE1: Perfect E Objects=waveguide
  1: Wave Port Faces=waveguide.face(+z) NumModes=1 Modes{Mode1{IntLine{middle of waveguide.edge(4 of 12) -> middle of waveguide.edge(2 of 12)} CharImp=Zpi}}
  2: Wave Port Faces=waveguide.face(-z) NumModes=1 Modes{Mode1{IntLine{middle of waveguide.edge(8 of 12) -> middle of waveguide.edge(6 of 12)} CharImp=Zpi}}
setups:
  Setup1: HfssDriven Frequency=10GHz MaxDeltaS=0.02 MaximumPasses=12 MinimumPasses=1 MinimumConvergedPasses=1 PercentRefinement=30 BasisOrder=1 PortAccuracy=2
    sweep Sweep: 5GHz to 17GHz step 0.1GHz; Type=Discrete
source amplitudes:
  1:1: 1W 0deg
  2:1: 0W 0deg
field plots:
  Vector_E1, Mag_E1: E Field in waveguide on Setup1 : LastAdaptive at Freq=10GHz Phase=0deg
reports:
  S Parameter Plot 1: dB(S(2,1)) vs Freq on Setup1 : Sweep
  Gamma Plot 1: im(Gamma(1:1)), im(Gamma(2:1)) vs Freq on Setup1 : Sweep
